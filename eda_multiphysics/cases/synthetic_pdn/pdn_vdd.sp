* Project-authored synthetic 3x3 PDN; Apache-2.0.
* R=0.1 ohm per edge, 1 mA load per node, center supply=1 V.
R0 VDD_20000_20000_1 VDD_50000_20000_1 0.1
R1 VDD_50000_20000_1 VDD_80000_20000_1 0.1
R2 VDD_20000_50000_1 VDD_50000_50000_1 0.1
R3 VDD_50000_50000_1 VDD_80000_50000_1 0.1
R4 VDD_20000_80000_1 VDD_50000_80000_1 0.1
R5 VDD_50000_80000_1 VDD_80000_80000_1 0.1
R6 VDD_20000_20000_1 VDD_20000_50000_1 0.1
R7 VDD_20000_50000_1 VDD_20000_80000_1 0.1
R8 VDD_50000_20000_1 VDD_50000_50000_1 0.1
R9 VDD_50000_50000_1 VDD_50000_80000_1 0.1
R10 VDD_80000_20000_1 VDD_80000_50000_1 0.1
R11 VDD_80000_50000_1 VDD_80000_80000_1 0.1
I0 VDD_20000_20000_1 0 0.001
I1 VDD_50000_20000_1 0 0.001
I2 VDD_80000_20000_1 0 0.001
I3 VDD_20000_50000_1 0 0.001
I4 VDD_50000_50000_1 0 0.001
I5 VDD_80000_50000_1 0 0.001
I6 VDD_20000_80000_1 0 0.001
I7 VDD_50000_80000_1 0 0.001
I8 VDD_80000_80000_1 0 0.001
V0 VDD_50000_50000_1 0 1
.OPTION NUMDGT=9
.OP
.END
